; Schematic connectivity helpers for physical wires and labels.
procedure(vcoStub(cv inst termName netName)
 let((term fig p q wire center ymin ymax pp tfig)
  term=dbFindTermByName(inst~>master termName)
  unless(term error("Missing master terminal %s/%s" inst~>name termName))
  fig=car(car(term~>pins)~>figs)
  unless(fig fig=car(term~>pins)~>fig)
  unless(fig error("Terminal has no pin figure %s" termName))
  p=dbTransformPoint(centerBox(fig~>bBox) inst~>transform)
  center=centerBox(inst~>bBox)
  ymin=1e20 ymax=-1e20
  foreach(tt inst~>master~>terminals
   tfig=car(car(tt~>pins)~>figs)
   unless(tfig tfig=car(tt~>pins)~>fig)
   pp=dbTransformPoint(centerBox(tfig~>bBox) inst~>transform)
   ymin=min(ymin yCoord(pp)) ymax=max(ymax yCoord(pp)))
  if(ymax-ymin>0.01 && (abs(yCoord(p)-ymax)<0.001 || abs(yCoord(p)-ymin)<0.001) then
   q=list(xCoord(p) yCoord(p)+if(abs(yCoord(p)-ymax)<0.001 then 0.375 else -0.375))
  else
   q=list(xCoord(p)+if(xCoord(p)>=xCoord(center) then 0.375 else -0.375) yCoord(p)))
  wire=car(schCreateWire(cv "draw" "full" list(p q) 0.0625 0.0625 0.0))
  unless(wire error("Wire creation failed"))
  schCreateWireLabel(cv wire q netName "centerCenter" "R0" "stick" 0.0625 nil)
 ))
procedure(vcoPort(cv name direction xy)
 let((master pin q wire)
  master=dbOpenCellViewByType("basic" "iopin" "symbol" "" "r")
  pin=schCreatePin(cv master name direction nil xy "R0")
  unless(pin error("Cannot create schematic pin %s" name))
  q=list(xCoord(xy)+0.375 yCoord(xy))
  wire=car(schCreateWire(cv "draw" "full" list(xy q) 0.0625 0.0625 0.0))
  schCreateWireLabel(cv wire q name "centerCenter" "R0" "stick" 0.0625 nil)
 ))

simulator('spectre)
unless(ddGetObj("example_tb") unless(ddCreateLib("example_tb" "/path/to/workspace/example_tb") error("create library failed"))
)
unless(equal(ddGetObj("example_tb")~>readPath "/path/to/workspace/example_tb") error("Target library path mismatch"))
when(ddGetObj("example_tb" "OscillatorTB") error("Refusing existing TB cell"))
unless(ddGetObj("example_tb" "isf_decimal_register")
f=ddGetObj("example_tb" "isf_decimal_register" "veriloga" "veriloga.va" nil "w")
unless(f error("VA view create failed"))
o=outfile(f~>writePath) fprintf(o "%s" "`include \"constants.vams\"\n`include \"disciplines.vams\"\nmodule isf_decimal_register(bits,vdd,vss);\n parameter integer WIDTH=4;\n parameter integer DEC_CODE=0;\n parameter integer INVERT=0 from [0:1];\n output [3:0] bits;\n inout vdd,vss;\n electrical [3:0] bits;\n electrical vdd,vss;\n genvar i;\n analog begin\n  @(initial_step) if (WIDTH!=4 || DEC_CODE<0 || DEC_CODE>=16)\n    $fatal(1,\"Invalid WIDTH or DEC_CODE\");\n  for(i=0;i<4;i=i+1) begin\n   V(bits[i],vss) <+ (((DEC_CODE>>i)&1)^INVERT)*V(vdd,vss);\n  end\n end\nendmodule\n") close(o) ddReleaseObj(f)
unless(ahdlUpdateViewInfo("example_tb" ?cell "isf_decimal_register" ?view "veriloga") error("VA interface extraction failed"))
cv=dbOpenCellViewByType("example_tb" "isf_decimal_register" "symbol" "schematicSymbol" "w")
dbCreateRect(cv list("device" "drawing") list(list(0 -0.5) list(2 1.5)))
n=dbCreateNet(cv "bits<3:0>") tm=dbCreateTerm(n "bits<3:0>" "output")
f=dbCreateRect(cv list("pin" "drawing") list(list(-0.025 -0.025) list(0.025 0.025)))
dbCreatePin(n f "bits<3:0>")
dbCreateLabel(cv list("device" "label") list(0.1 0.0) "bits<3:0>" "centerLeft" "R0" "roman" 0.0625)
n=dbCreateNet(cv "vdd") tm=dbCreateTerm(n "vdd" "inputOutput")
f=dbCreateRect(cv list("pin" "drawing") list(list(-0.025 0.475) list(0.025 0.525)))
dbCreatePin(n f "vdd")
dbCreateLabel(cv list("device" "label") list(0.1 0.5) "vdd" "centerLeft" "R0" "roman" 0.0625)
n=dbCreateNet(cv "vss") tm=dbCreateTerm(n "vss" "inputOutput")
f=dbCreateRect(cv list("pin" "drawing") list(list(-0.025 0.975) list(0.025 1.025)))
dbCreatePin(n f "vss")
dbCreateLabel(cv list("device" "label") list(0.1 1.0) "vss" "centerLeft" "R0" "roman" 0.0625)
dbReplaceProp(cv "instNamePrefix" "string" "I")
unless(dbSave(cv) error("symbol save failed"))
dbClose(cv)
c=cdfGetBaseCellCDF(ddGetObj("example_tb" "isf_decimal_register"))
unless(c c=cdfCreateBaseCellCDF(ddGetObj("example_tb" "isf_decimal_register")))
unless(cdfFindParamByName(c "WIDTH") cdfCreateParam(c ?name "WIDTH" ?type "string" ?defValue "4" ?parseAsCEL "yes" ?parseAsNumber "yes"))
unless(cdfFindParamByName(c "DEC_CODE") cdfCreateParam(c ?name "DEC_CODE" ?type "string" ?defValue "0" ?parseAsCEL "yes" ?parseAsNumber "yes"))
unless(cdfFindParamByName(c "INVERT") cdfCreateParam(c ?name "INVERT" ?type "string" ?defValue "0" ?parseAsCEL "yes" ?parseAsNumber "yes"))
cdfSaveCDF(c)
)
cv=dbOpenCellViewByType("example_tb" "OscillatorTB" "schematic" "schematic" "w")
unless(cv error("TB create failed"))
master=dbOpenCellViewByType("example_dut" "LC_VCO" "symbol" "" "r")
unless(master error("missing master LC_VCO"))
i=dbCreateInst(cv master "DUT" list(0 0) "R0")
unless(i error("instance create failed"))
vcoStub(cv i "VDD" "VDD")
vcoStub(cv i "VSS" "gnd!")
vcoStub(cv i "VDC" "VDC")
vcoStub(cv i "ENABLE" "ENABLE")
vcoStub(cv i "OUTP" "DUT_OUTP")
vcoStub(cv i "OUTN" "OUTN")
vcoStub(cv i "main_B0" "main_B0")
vcoStub(cv i "main_B1" "main_B1")
vcoStub(cv i "main_B2" "main_B2")
vcoStub(cv i "main_B3" "main_B3")
master=dbOpenCellViewByType("analogLib" "vsource" "symbol" "" "r")
unless(master error("missing master vsource"))
i=dbCreateInst(cv master "VDD_SRC" list(10 0) "R0")
unless(i error("instance create failed"))
vcoStub(cv i "PLUS" "VDD")
vcoStub(cv i "MINUS" "gnd!")
dbReplaceProp(i "srcType" "string" "dc")
dbReplaceProp(i "vdc" "string" "VDD")
master=dbOpenCellViewByType("analogLib" "vsource" "symbol" "" "r")
unless(master error("missing master vsource"))
i=dbCreateInst(cv master "BIAS_SRC" list(20 0) "R0")
unless(i error("instance create failed"))
vcoStub(cv i "PLUS" "VDC")
vcoStub(cv i "MINUS" "gnd!")
dbReplaceProp(i "srcType" "string" "dc")
dbReplaceProp(i "vdc" "string" "VDC")
master=dbOpenCellViewByType("analogLib" "vsource" "symbol" "" "r")
unless(master error("missing master vsource"))
i=dbCreateInst(cv master "ENABLE_SRC" list(30 0) "R0")
unless(i error("instance create failed"))
vcoStub(cv i "PLUS" "ENABLE")
vcoStub(cv i "MINUS" "gnd!")
dbReplaceProp(i "srcType" "string" "dc")
dbReplaceProp(i "vdc" "string" "VDD")
master=dbOpenCellViewByType("example_tb" "isf_decimal_register" "symbol" "" "r")
unless(master error("missing master isf_decimal_register"))
i=dbCreateInst(cv master "REG_MAIN" list(40 0) "R0")
unless(i error("instance create failed"))
vcoStub(cv i "bits<3:0>" "main_B3,main_B2,main_B1,main_B0")
vcoStub(cv i "vdd" "VDD")
vcoStub(cv i "vss" "gnd!")
dbReplaceProp(i "WIDTH" "string" "4")
dbReplaceProp(i "DEC_CODE" "string" "MAIN_CODE")
dbReplaceProp(i "INVERT" "string" "0")
master=dbOpenCellViewByType("analogLib" "iprobe" "symbol" "" "r")
unless(master error("missing master iprobe"))
i=dbCreateInst(cv master "OUTP_PROBE" list(0 -12) "R0")
unless(i error("instance create failed"))
vcoStub(cv i "PLUS" "OUTP")
vcoStub(cv i "MINUS" "DUT_OUTP")
schCheck(cv)
unless(dbSave(cv) error("TB save failed"))
dbClose(cv)
cv=dbOpenCellViewByType("example_tb" "OscillatorTB" "schematic" "" "r")
o=outfile("/path/to/workspace/transaction/connectivity.tsv")
foreach(inst cv~>instances foreach(it inst~>instTerms fprintf(o "%s\t%s\t%s\n" inst~>name it~>name it~>net~>name))) close(o) dbClose(cv)
h=hdbOpen("example_tb" "OscillatorTB" "config" "w")
unless(h error("config create failed"))
unless(hdbSetTopCellViewName(h "example_tb" "OscillatorTB" "schematic") error("config write failed"))
unless(hdbSetDefaultViewListString(h "spectre veriloga schematic") error("config write failed"))
unless(hdbSetDefaultStopListString(h "spectre veriloga") error("config write failed"))
unless(hdbSave(h) error("config write failed"))
hdbClose(h)
h=hdbOpen("example_tb" "OscillatorTB" "config" "a")
unless(hdbSetObjBindRule(h list(list("example_tb" "OscillatorTB" "schematic" "DUT")) list('hdbcBindingRule list("example_dut" "LC_VCO" "schematic"))) error("DUT view binding failed"))
unless(hdbSave(h) error("bound config save failed"))
hdbClose(h)

envSetVal("asimenv.startup" "projectDir" 'string "/path/to/workspace/simulation")
envSetVal("adexl.historyNamePrefix" "showNameHistoryForm" 'boolean nil)
envSetVal("adexl.simulation" "saveLastNHistoryEntries" 'int 1000)
s=maeOpenSetup("example_tb" "OscillatorTB" "maestro" ?mode "a")
unless(s error("open setup failed"))
when(axlIsSessionReadOnly(s) error("SETUP_OPEN_OR_LOCKED: close GUI or use an in-GUI plugin"))
tbgenOriginalTests=maeGetSetup(?session s) tbgenEnabledTests=maeGetSetup(?enabled t ?session s)
when(member("Oscillator" maeGetSetup(?session s)) error("Test name already exists"))
unless(maeCreateTest("Oscillator" ?lib "example_tb" ?cell "OscillatorTB" ?view "config" ?simulator "spectre" ?session s) error("create test failed"))
unless(maeSetEnvOption("Oscillator" ?options list(list("controlMode" "batch") list("analysisOrder" list("hb" "hbnoise")) list("modelFiles" list(list("/path/to/models.scs" "typical"))) list("stimulusFile" list("/path/to/workspace/initial_conditions.scs"))) ?session s) error("set environment failed"))
unless(maeSetVar("VDD" "1.0" ?typeValue list("Oscillator") ?session s) error("set variable failed"))
unless(equal(maeGetVar("VDD" ?typeName "test" ?typeValue "Oscillator" ?session s) "1.0") error("variable readback mismatch"))
unless(maeSetVar("VDC" "0.5" ?typeValue list("Oscillator") ?session s) error("set variable failed"))
unless(equal(maeGetVar("VDC" ?typeName "test" ?typeValue "Oscillator" ?session s) "0.5") error("variable readback mismatch"))
unless(maeSetVar("MAIN_CODE" "4" ?typeValue list("Oscillator") ?session s) error("set variable failed"))
unless(equal(maeGetVar("MAIN_CODE" ?typeName "test" ?typeValue "Oscillator" ?session s) "4") error("variable readback mismatch"))
printf("ENABLE_TEST_VARS %L\n" maeSetEnableTestVar("Oscillator" list("VDD" "VDC" "MAIN_CODE") ?enabled t ?session s))
unless(maeSetSimOption("Oscillator" ?options list(list("temp" "25") list("reltol" "1e-4")) ?session s) error("simulator options failed"))
unless(maeSetAnalysis("Oscillator" "hb" ?enable t ?options list(list("oscana" t) list("p" "/OUTP") list("n" "/OUTN") list("HBFreq1" "1G") list("HBHarm1" "15") list("fundfreqs" list("1G")) list("maxharms" list("15")) list("errpreset" "conservative") list("oscic" "lin") list("oscmethod" "twotier") list("pinnode" "/OUTP") list("pinnodeminus" "/OUTN") list("pinnoderank" "1") list("autosteady" "yes")) ?session s) error("set analysis failed hb"))
unless(equal(maeGetAnalysis("Oscillator" "hb" ?option "oscana" ?session s) t) error("analysis option readback mismatch: hb/oscana"))
unless(equal(maeGetAnalysis("Oscillator" "hb" ?option "p" ?session s) "/OUTP") error("analysis option readback mismatch: hb/p"))
unless(equal(maeGetAnalysis("Oscillator" "hb" ?option "n" ?session s) "/OUTN") error("analysis option readback mismatch: hb/n"))
unless(equal(maeGetAnalysis("Oscillator" "hb" ?option "HBFreq1" ?session s) "1G") error("analysis option readback mismatch: hb/HBFreq1"))
unless(equal(maeGetAnalysis("Oscillator" "hb" ?option "HBHarm1" ?session s) "15") error("analysis option readback mismatch: hb/HBHarm1"))
unless(equal(maeGetAnalysis("Oscillator" "hb" ?option "fundfreqs" ?session s) list("1G")) error("analysis option readback mismatch: hb/fundfreqs"))
unless(equal(maeGetAnalysis("Oscillator" "hb" ?option "maxharms" ?session s) list("15")) error("analysis option readback mismatch: hb/maxharms"))
unless(equal(maeGetAnalysis("Oscillator" "hb" ?option "errpreset" ?session s) "conservative") error("analysis option readback mismatch: hb/errpreset"))
unless(equal(maeGetAnalysis("Oscillator" "hb" ?option "oscic" ?session s) "lin") error("analysis option readback mismatch: hb/oscic"))
unless(equal(maeGetAnalysis("Oscillator" "hb" ?option "oscmethod" ?session s) "twotier") error("analysis option readback mismatch: hb/oscmethod"))
unless(equal(maeGetAnalysis("Oscillator" "hb" ?option "pinnode" ?session s) "/OUTP") error("analysis option readback mismatch: hb/pinnode"))
unless(equal(maeGetAnalysis("Oscillator" "hb" ?option "pinnodeminus" ?session s) "/OUTN") error("analysis option readback mismatch: hb/pinnodeminus"))
unless(equal(maeGetAnalysis("Oscillator" "hb" ?option "pinnoderank" ?session s) "1") error("analysis option readback mismatch: hb/pinnoderank"))
unless(equal(maeGetAnalysis("Oscillator" "hb" ?option "autosteady" ?session s) "yes") error("analysis option readback mismatch: hb/autosteady"))
unless(maeSetAnalysis("Oscillator" "hbnoise" ?enable t ?options list(list("sweeptype" "relative") list("relharmvec" list("1")) list("outType" "voltage") list("p" "/OUTP") list("n" "/OUTN") list("maxsideband" "15") list("start" "") list("stop" "") list("incrType" "Automatic") list("dec" "") list("useDiscrete" t) list("values" list("10000.0" "20000.0")) list("noisetype" "timeaverage") list("noiseout" list("pm"))) ?session s) error("set analysis failed hbnoise"))
unless(equal(maeGetAnalysis("Oscillator" "hbnoise" ?option "sweeptype" ?session s) "relative") error("analysis option readback mismatch: hbnoise/sweeptype"))
unless(equal(maeGetAnalysis("Oscillator" "hbnoise" ?option "relharmvec" ?session s) list("1")) error("analysis option readback mismatch: hbnoise/relharmvec"))
unless(equal(maeGetAnalysis("Oscillator" "hbnoise" ?option "outType" ?session s) "voltage") error("analysis option readback mismatch: hbnoise/outType"))
unless(equal(maeGetAnalysis("Oscillator" "hbnoise" ?option "p" ?session s) "/OUTP") error("analysis option readback mismatch: hbnoise/p"))
unless(equal(maeGetAnalysis("Oscillator" "hbnoise" ?option "n" ?session s) "/OUTN") error("analysis option readback mismatch: hbnoise/n"))
unless(equal(maeGetAnalysis("Oscillator" "hbnoise" ?option "maxsideband" ?session s) "15") error("analysis option readback mismatch: hbnoise/maxsideband"))
unless(equal(maeGetAnalysis("Oscillator" "hbnoise" ?option "start" ?session s) "") error("analysis option readback mismatch: hbnoise/start"))
unless(equal(maeGetAnalysis("Oscillator" "hbnoise" ?option "stop" ?session s) "") error("analysis option readback mismatch: hbnoise/stop"))
unless(equal(maeGetAnalysis("Oscillator" "hbnoise" ?option "incrType" ?session s) "Automatic") error("analysis option readback mismatch: hbnoise/incrType"))
unless(equal(maeGetAnalysis("Oscillator" "hbnoise" ?option "dec" ?session s) "") error("analysis option readback mismatch: hbnoise/dec"))
unless(equal(maeGetAnalysis("Oscillator" "hbnoise" ?option "useDiscrete" ?session s) t) error("analysis option readback mismatch: hbnoise/useDiscrete"))
unless(equal(maeGetAnalysis("Oscillator" "hbnoise" ?option "values" ?session s) list("10000.0" "20000.0")) error("analysis option readback mismatch: hbnoise/values"))
unless(equal(maeGetAnalysis("Oscillator" "hbnoise" ?option "noisetype" ?session s) "timeaverage") error("analysis option readback mismatch: hbnoise/noisetype"))
unless(equal(maeGetAnalysis("Oscillator" "hbnoise" ?option "noiseout" ?session s) list("pm")) error("analysis option readback mismatch: hbnoise/noiseout"))
unless(maeAddOutput("VDD_VALUE" "Oscillator" ?expr "VAR(\"VDD\")" ?plot t ?save t ?session s) error("add output failed"))
unless(maeAddOutput("VCO_HB_F0_Hz" "Oscillator" ?expr "drGetElem(drGetWaveformXVec(getData(\"/OUTP\" ?result \"hb_fd\")) 1)" ?plot t ?save t ?session s) error("add output failed"))
unless(maeAddOutput("VCO_HB_DIFF_PEAK_V" "Oscillator" ?expr "mag(value((getData(\"/OUTP\" ?result \"hb_fd\")-getData(\"/OUTN\" ?result \"hb_fd\")) drGetElem(drGetWaveformXVec(getData(\"/OUTP\" ?result \"hb_fd\")) 1)))" ?plot t ?save t ?session s) error("add output failed"))
unless(maeAddOutput("VCO_HB_VDD_SRC_IDC_A" "Oscillator" ?expr "0-real(value(getData(\"/VDD_SRC/PLUS\" ?result \"hb_fd\") 0))" ?plot t ?save t ?session s) error("add output failed"))
unless(maeAddOutput("VCO_HB_VDD_SRC_PDC_W" "Oscillator" ?expr "(0-real(value((0+getData(\"/VDD\" ?result \"hb_fd\")) 0))*real(value(getData(\"/VDD_SRC/PLUS\" ?result \"hb_fd\") 0)))" ?plot t ?save t ?session s) error("add output failed"))
unless(maeAddOutput("VCO_HBNOISE_PN_10000Hz_dBc_Hz" "Oscillator" ?expr "(10*log10(2)+20*log10(value(getData(\"out\" ?result \"hbnoise_pm\") 10000.0)/mag(value((getData(\"/OUTP\" ?result \"hb_fd\")-getData(\"/OUTN\" ?result \"hb_fd\")) drGetElem(drGetWaveformXVec(getData(\"/OUTP\" ?result \"hb_fd\")) 1)))))" ?plot t ?save t ?session s) error("add output failed"))
unless(maeAddOutput("VCO_HBNOISE_FOM_10000Hz_dB" "Oscillator" ?expr "(10*log10(2)+20*log10(value(getData(\"out\" ?result \"hbnoise_pm\") 10000.0)/mag(value((getData(\"/OUTP\" ?result \"hb_fd\")-getData(\"/OUTN\" ?result \"hb_fd\")) drGetElem(drGetWaveformXVec(getData(\"/OUTP\" ?result \"hb_fd\")) 1)))))-20*log10(drGetElem(drGetWaveformXVec(getData(\"/OUTP\" ?result \"hb_fd\")) 1)/10000.0)+10*log10(1000*(0+(0-real(value((0+getData(\"/VDD\" ?result \"hb_fd\")) 0))*real(value(getData(\"/VDD_SRC/PLUS\" ?result \"hb_fd\") 0)))))" ?plot t ?save t ?session s) error("add output failed"))
unless(maeAddOutput("SAVE_/OUTP" "Oscillator" ?outputType "net" ?signalName "/OUTP" ?plot nil ?save t ?session s) error("add save failed"))
unless(maeAddOutput("SAVE_/OUTN" "Oscillator" ?outputType "net" ?signalName "/OUTN" ?plot nil ?save t ?session s) error("add save failed"))
unless(maeAddOutput("SAVE_/VDD" "Oscillator" ?outputType "net" ?signalName "/VDD" ?plot nil ?save t ?session s) error("add save failed"))
unless(maeAddOutput("SAVE_/VDD_SRC/PLUS" "Oscillator" ?outputType "terminal" ?signalName "/VDD_SRC/PLUS" ?plot nil ?save t ?session s) error("add save failed"))
unless(maeSaveSetup(?session s) error("save setup failed"))
maeCloseSession(?session s)
envSetVal("asimenv.startup" "projectDir" 'string "/path/to/workspace/simulation")
envSetVal("adexl.historyNamePrefix" "showNameHistoryForm" 'boolean nil)
envSetVal("adexl.simulation" "saveLastNHistoryEntries" 'int 1000)
s=maeOpenSetup("example_tb" "OscillatorTB" "maestro" ?mode "r")
unless(s error("open setup failed"))
o=outfile("/path/to/workspace/setup-readback.txt")
fprintf(o "TESTS %L\n" maeGetSetup(?session s))
fprintf(o "hb %L\n" maeGetAnalysis("Oscillator" "hb" ?session s))
unless(equal(maeGetAnalysis("Oscillator" "hb" ?option "oscana" ?session s) t) error("reopen analysis mismatch"))
unless(equal(maeGetAnalysis("Oscillator" "hb" ?option "p" ?session s) "/OUTP") error("reopen analysis mismatch"))
unless(equal(maeGetAnalysis("Oscillator" "hb" ?option "n" ?session s) "/OUTN") error("reopen analysis mismatch"))
unless(equal(maeGetAnalysis("Oscillator" "hb" ?option "HBFreq1" ?session s) "1G") error("reopen analysis mismatch"))
unless(equal(maeGetAnalysis("Oscillator" "hb" ?option "HBHarm1" ?session s) "15") error("reopen analysis mismatch"))
unless(equal(maeGetAnalysis("Oscillator" "hb" ?option "fundfreqs" ?session s) list("1G")) error("reopen analysis mismatch"))
unless(equal(maeGetAnalysis("Oscillator" "hb" ?option "maxharms" ?session s) list("15")) error("reopen analysis mismatch"))
unless(equal(maeGetAnalysis("Oscillator" "hb" ?option "errpreset" ?session s) "conservative") error("reopen analysis mismatch"))
unless(equal(maeGetAnalysis("Oscillator" "hb" ?option "oscic" ?session s) "lin") error("reopen analysis mismatch"))
unless(equal(maeGetAnalysis("Oscillator" "hb" ?option "oscmethod" ?session s) "twotier") error("reopen analysis mismatch"))
unless(equal(maeGetAnalysis("Oscillator" "hb" ?option "pinnode" ?session s) "/OUTP") error("reopen analysis mismatch"))
unless(equal(maeGetAnalysis("Oscillator" "hb" ?option "pinnodeminus" ?session s) "/OUTN") error("reopen analysis mismatch"))
unless(equal(maeGetAnalysis("Oscillator" "hb" ?option "pinnoderank" ?session s) "1") error("reopen analysis mismatch"))
unless(equal(maeGetAnalysis("Oscillator" "hb" ?option "autosteady" ?session s) "yes") error("reopen analysis mismatch"))
fprintf(o "hbnoise %L\n" maeGetAnalysis("Oscillator" "hbnoise" ?session s))
unless(equal(maeGetAnalysis("Oscillator" "hbnoise" ?option "sweeptype" ?session s) "relative") error("reopen analysis mismatch"))
unless(equal(maeGetAnalysis("Oscillator" "hbnoise" ?option "relharmvec" ?session s) list("1")) error("reopen analysis mismatch"))
unless(equal(maeGetAnalysis("Oscillator" "hbnoise" ?option "outType" ?session s) "voltage") error("reopen analysis mismatch"))
unless(equal(maeGetAnalysis("Oscillator" "hbnoise" ?option "p" ?session s) "/OUTP") error("reopen analysis mismatch"))
unless(equal(maeGetAnalysis("Oscillator" "hbnoise" ?option "n" ?session s) "/OUTN") error("reopen analysis mismatch"))
unless(equal(maeGetAnalysis("Oscillator" "hbnoise" ?option "maxsideband" ?session s) "15") error("reopen analysis mismatch"))
unless(equal(maeGetAnalysis("Oscillator" "hbnoise" ?option "start" ?session s) "") error("reopen analysis mismatch"))
unless(equal(maeGetAnalysis("Oscillator" "hbnoise" ?option "stop" ?session s) "") error("reopen analysis mismatch"))
unless(equal(maeGetAnalysis("Oscillator" "hbnoise" ?option "incrType" ?session s) "Automatic") error("reopen analysis mismatch"))
unless(equal(maeGetAnalysis("Oscillator" "hbnoise" ?option "dec" ?session s) "") error("reopen analysis mismatch"))
unless(equal(maeGetAnalysis("Oscillator" "hbnoise" ?option "useDiscrete" ?session s) t) error("reopen analysis mismatch"))
unless(equal(maeGetAnalysis("Oscillator" "hbnoise" ?option "values" ?session s) list("10000.0" "20000.0")) error("reopen analysis mismatch"))
unless(equal(maeGetAnalysis("Oscillator" "hbnoise" ?option "noisetype" ?session s) "timeaverage") error("reopen analysis mismatch"))
unless(equal(maeGetAnalysis("Oscillator" "hbnoise" ?option "noiseout" ?session s) list("pm")) error("reopen analysis mismatch"))
fprintf(o "ENV %L\nVARS %L\n" maeGetEnvOption("Oscillator" ?session s) maeGetSetup(?typeName "variables" ?session s))
close(o) maeCloseSession(?session s)

; Preserve explicit family coordinates (not inferred signal-name sidebands).
procedure(tbgenEmitWave(out analysisName signalName wave coordinates)
 let((xx yy vv xv)
  cond(
   (numberp(wave)
    fprintf(out "RAW\t%L\t%s\t0\t%.17g\t%.17g\n" analysisName signalName real(wave)*1.0 imag(wave)*1.0))
   (drIsWaveform(wave)
    xx=drGetWaveformXVec(wave) yy=drGetWaveformYVec(wave)
    for(index 0 min(2 drVectorLength(xx)-1)
     vv=drGetElem(yy index) xv=drGetElem(xx index)
     when(numberp(vv) && numberp(xv)
      fprintf(out "FAMILY_RAW\t%L\t%s\t%L\t%.17g\t%.17g\t%.17g\n"
       analysisName signalName coordinates xv real(vv) imag(vv)))))
   (famIsFamily(wave)
    foreach(coordinate famGetSweepValues(wave)
     tbgenEmitWave(out analysisName signalName famValue(wave coordinate)
      append(coordinates list(list(famGetSweepName(wave) coordinate))))))
 ))
)

; Required expression waves export all actual samples, units and family coordinates.
procedure(tbgenEmitOutput(out outputName wave coordinates)
 let((xx yy vv xv)
  cond(
   (numberp(wave)
    fprintf(out "SCALAR_SAMPLE\t%s\t%.17g\t%.17g\n" outputName real(wave)*1.0 imag(wave)*1.0))
   (drIsWaveform(wave)
    xx=drGetWaveformXVec(wave) yy=drGetWaveformYVec(wave)
    fprintf(out "WAVE_META\t%s\t%L\t%L\t%L\n" outputName coordinates xx->units yy->units)
    for(index 0 drVectorLength(xx)-1
     vv=drGetElem(yy index) xv=drGetElem(xx index)
     fprintf(out "WAVE_SAMPLE\t%s\t%.17g\t%.17g\t%.17g\n" outputName xv real(vv) imag(vv))))
   (famIsFamily(wave)
    foreach(coordinate famGetSweepValues(wave)
     tbgenEmitOutput(out outputName famValue(wave coordinate)
      append(coordinates list(list(famGetSweepName(wave) coordinate)))))))))

envSetVal("asimenv.startup" "projectDir" 'string "/path/to/workspace/simulation")
envSetVal("adexl.historyNamePrefix" "showNameHistoryForm" 'boolean nil)
envSetVal("adexl.simulation" "saveLastNHistoryEntries" 'int 1000)
s=maeOpenSetup("example_tb" "OscillatorTB" "maestro" ?mode "a")
unless(s error("open setup failed"))
when(axlIsSessionReadOnly(s) error("SETUP_OPEN_OR_LOCKED: close GUI or use an in-GUI plugin"))
unless(equal(sort(maeGetEnabledAnalysis("Oscillator" ?session s) 'alphalessp) sort(list("hb" "hbnoise") 'alphalessp)) error("effective analyses changed"))
unless(equal(maeGetAnalysis("Oscillator" "hb" ?option "oscana" ?session s) t) error("effective measurement option changed"))
unless(equal(maeGetAnalysis("Oscillator" "hb" ?option "p" ?session s) "/OUTP") error("effective measurement option changed"))
unless(equal(maeGetAnalysis("Oscillator" "hb" ?option "n" ?session s) "/OUTN") error("effective measurement option changed"))
unless(equal(maeGetAnalysis("Oscillator" "hb" ?option "HBFreq1" ?session s) "1G") error("effective measurement option changed"))
unless(equal(maeGetAnalysis("Oscillator" "hb" ?option "HBHarm1" ?session s) "15") error("effective measurement option changed"))
unless(equal(maeGetAnalysis("Oscillator" "hb" ?option "fundfreqs" ?session s) list("1G")) error("effective measurement option changed"))
unless(equal(maeGetAnalysis("Oscillator" "hb" ?option "maxharms" ?session s) list("15")) error("effective measurement option changed"))
unless(equal(maeGetAnalysis("Oscillator" "hb" ?option "errpreset" ?session s) "conservative") error("effective measurement option changed"))
unless(equal(maeGetAnalysis("Oscillator" "hb" ?option "oscic" ?session s) "lin") error("effective measurement option changed"))
unless(equal(maeGetAnalysis("Oscillator" "hb" ?option "oscmethod" ?session s) "twotier") error("effective measurement option changed"))
unless(equal(maeGetAnalysis("Oscillator" "hb" ?option "pinnode" ?session s) "/OUTP") error("effective measurement option changed"))
unless(equal(maeGetAnalysis("Oscillator" "hb" ?option "pinnodeminus" ?session s) "/OUTN") error("effective measurement option changed"))
unless(equal(maeGetAnalysis("Oscillator" "hb" ?option "pinnoderank" ?session s) "1") error("effective measurement option changed"))
unless(equal(maeGetAnalysis("Oscillator" "hb" ?option "autosteady" ?session s) "yes") error("effective measurement option changed"))
unless(equal(maeGetAnalysis("Oscillator" "hbnoise" ?option "sweeptype" ?session s) "relative") error("effective measurement option changed"))
unless(equal(maeGetAnalysis("Oscillator" "hbnoise" ?option "relharmvec" ?session s) list("1")) error("effective measurement option changed"))
unless(equal(maeGetAnalysis("Oscillator" "hbnoise" ?option "outType" ?session s) "voltage") error("effective measurement option changed"))
unless(equal(maeGetAnalysis("Oscillator" "hbnoise" ?option "p" ?session s) "/OUTP") error("effective measurement option changed"))
unless(equal(maeGetAnalysis("Oscillator" "hbnoise" ?option "n" ?session s) "/OUTN") error("effective measurement option changed"))
unless(equal(maeGetAnalysis("Oscillator" "hbnoise" ?option "maxsideband" ?session s) "15") error("effective measurement option changed"))
unless(equal(maeGetAnalysis("Oscillator" "hbnoise" ?option "start" ?session s) "") error("effective measurement option changed"))
unless(equal(maeGetAnalysis("Oscillator" "hbnoise" ?option "stop" ?session s) "") error("effective measurement option changed"))
unless(equal(maeGetAnalysis("Oscillator" "hbnoise" ?option "incrType" ?session s) "Automatic") error("effective measurement option changed"))
unless(equal(maeGetAnalysis("Oscillator" "hbnoise" ?option "dec" ?session s) "") error("effective measurement option changed"))
unless(equal(maeGetAnalysis("Oscillator" "hbnoise" ?option "useDiscrete" ?session s) t) error("effective measurement option changed"))
unless(equal(maeGetAnalysis("Oscillator" "hbnoise" ?option "values" ?session s) list("10000.0" "20000.0")) error("effective measurement option changed"))
unless(equal(maeGetAnalysis("Oscillator" "hbnoise" ?option "noisetype" ?session s) "timeaverage") error("effective measurement option changed"))
unless(equal(maeGetAnalysis("Oscillator" "hbnoise" ?option "noiseout" ?session s) list("pm")) error("effective measurement option changed"))
modeBefore=maeGetEnvOption("Oscillator" ?option "controlMode" ?session s)
unless(maeSetEnvOption("Oscillator" ?options list(list("controlMode" "batch")) ?session s) error("set batch mode failed"))
unless(equal(maeGetEnvOption("Oscillator" ?option "controlMode" ?session s) "batch") error("batch mode readback mismatch"))
enabledBefore=maeGetSetup(?enabled t ?session s)
maeSetSetup(?tests maeGetSetup(?session s) ?enabled nil ?session s)
maeSetSetup(?tests list("Oscillator") ?enabled t ?session s)
runResult=errset(progn(
runId=maeRunSimulation(?waitUntilDone t ?returnRunId t ?session s)
unless(runId error("submission failed"))
maeWaitUntilDone('All ?session s)
maeExportOutputView(?fileName "/path/to/workspace/run/evaluated.csv" ?session s)
maeWaitUntilDone('All ?session s)
rd=axlGetRunData(s runId) hist=axlGetHistoryName(rd)
r=maeReadResDB(?historyName hist ?session s)
unless(r error("missing RDB"))
o=outfile("/path/to/workspace/run/points.tsv")
fprintf(o "HISTORY\t%s\n" hist)
he=axlGetHistoryEntry(axlGetMainSetupDB(s) hist)
fprintf(o "RDB\t%s\n" axlGetHistoryResults(he))
tbgenReadSignals=list("/DUT_OUTP" "/ENABLE" "/OUTN" "/OUTP" "/VDC" "/VDD" "/VDD_SRC/PLUS" "/main_B0" "/main_B1" "/main_B2" "/main_B3")
tbgenRequiredSignals=list("/OUTP" "/OUTN" "/VDD" "/VDD_SRC/PLUS")
tbgenNumberedDrain=nil
tbgenAnalysisNames=list("hb_fd" "hb_fi" "hb_td" "hbnoise" "hbnoise_pm")
tbgenExpressions=list(list("VDD_VALUE" "VAR(\"VDD\")") list("VCO_HB_F0_Hz" "drGetElem(drGetWaveformXVec(getData(\"/OUTP\" ?result \"hb_fd\")) 1)") list("VCO_HB_DIFF_PEAK_V" "mag(value((getData(\"/OUTP\" ?result \"hb_fd\")-getData(\"/OUTN\" ?result \"hb_fd\")) drGetElem(drGetWaveformXVec(getData(\"/OUTP\" ?result \"hb_fd\")) 1)))") list("VCO_HB_VDD_SRC_IDC_A" "0-real(value(getData(\"/VDD_SRC/PLUS\" ?result \"hb_fd\") 0))") list("VCO_HB_VDD_SRC_PDC_W" "(0-real(value((0+getData(\"/VDD\" ?result \"hb_fd\")) 0))*real(value(getData(\"/VDD_SRC/PLUS\" ?result \"hb_fd\") 0)))") list("VCO_HBNOISE_PN_10000Hz_dBc_Hz" "(10*log10(2)+20*log10(value(getData(\"out\" ?result \"hbnoise_pm\") 10000.0)/mag(value((getData(\"/OUTP\" ?result \"hb_fd\")-getData(\"/OUTN\" ?result \"hb_fd\")) drGetElem(drGetWaveformXVec(getData(\"/OUTP\" ?result \"hb_fd\")) 1)))))") list("VCO_HBNOISE_FOM_10000Hz_dB" "(10*log10(2)+20*log10(value(getData(\"out\" ?result \"hbnoise_pm\") 10000.0)/mag(value((getData(\"/OUTP\" ?result \"hb_fd\")-getData(\"/OUTN\" ?result \"hb_fd\")) drGetElem(drGetWaveformXVec(getData(\"/OUTP\" ?result \"hb_fd\")) 1)))))-20*log10(drGetElem(drGetWaveformXVec(getData(\"/OUTP\" ?result \"hb_fd\")) 1)/10000.0)+10*log10(1000*(0+(0-real(value((0+getData(\"/VDD\" ?result \"hb_fd\")) 0))*real(value(getData(\"/VDD_SRC/PLUS\" ?result \"hb_fd\") 0)))))"))
foreach(point r->points() foreach(corner point->corners() foreach(test corner->tests()
 fprintf(o "POINT\t%L\t%s\t%s\t%L\t%s\n" point->id corner->name test->name test->status test->resultsDir)
 foreach(param corner->params() fprintf(o "PARAM\t%s\t%L\n" param->name param->value))
 tbgenWaveNames=nil
 foreach(value test->outputs() when(member(value->value list("wave" 'wave)) tbgenWaveNames=cons(value->name tbgenWaveNames)) fprintf(o "OUTPUT\t%s\t%L\t%L\n" value->name value->type value->value))
 when(test->status=='done
  openResults(strcat(test->resultsDir "/psf"))
  foreach(ana results()
   fprintf(o "ANALYSIS\t%L\n" ana)
   when(member(if(symbolp(ana) then symbolToString(ana) else ana) tbgenAnalysisNames)
   tbgenActualSignals=outputs(?result ana)
   when(tbgenNumberedDrain && member(ana '(hb_fd hb_td))
    tbgenNumberedWave=nil
    foreach(alias cadr(tbgenNumberedDrain)
     unless(tbgenNumberedWave
      waveResult=errset(getData(alias ?result ana) nil)
      when(waveResult tbgenNumberedWave=car(waveResult))))
    when(tbgenNumberedWave
     tbgenSignal=car(tbgenNumberedDrain)
     tbgenEmitWave(o ana tbgenSignal tbgenNumberedWave nil)
     tbgenEmitOutput(o strcat("__save__" tbgenSignal) tbgenNumberedWave nil)))
   foreach(signal append(tbgenActualSignals if(member(ana '(hbnoise_pm pnoise)) then list("out") else nil))
    when(member(signal tbgenReadSignals) || ana=='hbxf || signal=="out" || signal==car(tbgenActualSignals)
    waveResult=errset(getData(signal ?result ana) nil)
    when(waveResult
     tbgenEmitWave(o ana signal car(waveResult) nil)
     when(member(signal tbgenRequiredSignals) tbgenEmitOutput(o strcat("__save__" signal) car(waveResult) nil)))))))
  foreach(expression tbgenExpressions
   when(member(car(expression) tbgenWaveNames)
   waveResult=errset(evalstring(cadr(expression)) nil)
   when(waveResult tbgenEmitOutput(o car(expression) car(waveResult) nil))))
))))
close(o)
) t)
maeSetEnvOption("Oscillator" ?options list(list("controlMode" modeBefore)) ?session s)
maeSetSetup(?tests maeGetSetup(?session s) ?enabled nil ?session s)
maeSetSetup(?tests enabledBefore ?enabled t ?session s)
maeSaveSetup(?session s) maeCloseSession(?session s)
unless(runResult error("simulation/result export failed"))
